_vWBL_EN\\<0\\> (WBL_EN\\<0\\> 0) vsource val0=0 val1=0 period=70n delay=14n rise=1n fall=1n width=12n type=pulse
_vWBL_EN\\<1\\> (WBL_EN\\<1\\> 0) vsource val0=0 val1=1.8 period=70n delay=14n rise=1n fall=1n width=12n type=pulse
_vWBL_EN\\<2\\> (WBL_EN\\<2\\> 0) vsource val0=0 val1=1.8 period=70n delay=14n rise=1n fall=1n width=12n type=pulse
_vWBL_EN\\<3\\> (WBL_EN\\<3\\> 0) vsource val0=0 val1=1.8 period=70n delay=14n rise=1n fall=1n width=12n type=pulse
_vWBL_EN\\<4\\> (WBL_EN\\<4\\> 0) vsource val0=0 val1=1.8 period=70n delay=14n rise=1n fall=1n width=12n type=pulse
_vWBL_EN\\<5\\> (WBL_EN\\<5\\> 0) vsource val0=0 val1=1.8 period=70n delay=14n rise=1n fall=1n width=12n type=pulse
_vWBL_EN\\<6\\> (WBL_EN\\<6\\> 0) vsource val0=0 val1=1.8 period=70n delay=14n rise=1n fall=1n width=12n type=pulse
_vWBL_EN\\<7\\> (WBL_EN\\<7\\> 0) vsource val0=0 val1=1.8 period=70n delay=14n rise=1n fall=1n width=12n type=pulse
_vWBL_EN\\<8\\> (WBL_EN\\<8\\> 0) vsource val0=0 val1=1.8 period=70n delay=14n rise=1n fall=1n width=12n type=pulse
_vWBL_EN\\<9\\> (WBL_EN\\<9\\> 0) vsource val0=0 val1=1.8 period=70n delay=14n rise=1n fall=1n width=12n type=pulse
_vWBL_EN\\<10\\> (WBL_EN\\<10\\> 0) vsource val0=0 val1=1.8 period=70n delay=14n rise=1n fall=1n width=12n type=pulse
_vWBL_EN\\<11\\> (WBL_EN\\<11\\> 0) vsource val0=0 val1=1.8 period=70n delay=14n rise=1n fall=1n width=12n type=pulse
_vWBL_EN\\<12\\> (WBL_EN\\<12\\> 0) vsource val0=0 val1=1.8 period=70n delay=14n rise=1n fall=1n width=12n type=pulse
_vWBL_EN\\<13\\> (WBL_EN\\<13\\> 0) vsource val0=0 val1=1.8 period=70n delay=14n rise=1n fall=1n width=12n type=pulse
_vWBL_EN\\<15\\> (WBL_EN\\<15\\> 0) vsource val0=0 val1=1.8 period=70n delay=14n rise=1n fall=1n width=12n type=pulse
_vWBL_EN\\<14\\> (WBL_EN\\<14\\> 0) vsource val0=0 val1=1.8 period=70n delay=14n rise=1n fall=1n width=12n type=pulse

_vRBL_EN\\<0\\> (RBL_EN\\<0\\> 0) vsource val0=1.8 val1=0 period=70n delay=14n rise=1n fall=1n width=12n type=pulse
_vRBL_EN\\<1\\> (RBL_EN\\<1\\> 0) vsource val0=1.8 val1=0 period=70n delay=14n rise=1n fall=1n width=12n type=pulse
_vRBL_EN\\<2\\> (RBL_EN\\<2\\> 0) vsource val0=1.8 val1=0 period=70n delay=14n rise=1n fall=1n width=12n type=pulse
_vRBL_EN\\<3\\> (RBL_EN\\<3\\> 0) vsource val0=1.8 val1=0 period=70n delay=14n rise=1n fall=1n width=12n type=pulse
_vRBL_EN\\<4\\> (RBL_EN\\<4\\> 0) vsource val0=1.8 val1=0 period=70n delay=14n rise=1n fall=1n width=12n type=pulse
_vRBL_EN\\<5\\> (RBL_EN\\<5\\> 0) vsource val0=1.8 val1=0 period=70n delay=14n rise=1n fall=1n width=12n type=pulse
_vRBL_EN\\<6\\> (RBL_EN\\<6\\> 0) vsource val0=1.8 val1=0 period=70n delay=14n rise=1n fall=1n width=12n type=pulse
_vRBL_EN\\<7\\> (RBL_EN\\<7\\> 0) vsource val0=1.8 val1=0 period=70n delay=14n rise=1n fall=1n width=12n type=pulse
_vRBL_EN\\<8\\> (RBL_EN\\<8\\> 0) vsource val0=1.8 val1=0 period=70n delay=14n rise=1n fall=1n width=12n type=pulse
_vRBL_EN\\<9\\> (RBL_EN\\<9\\> 0) vsource val0=1.8 val1=0 period=70n delay=14n rise=1n fall=1n width=12n type=pulse
_vRBL_EN\\<10\\> (RBL_EN\\<10\\> 0) vsource val0=1.8 val1=0 period=70n delay=14n rise=1n fall=1n width=12n type=pulse
_vRBL_EN\\<11\\> (RBL_EN\\<11\\> 0) vsource val0=1.8 val1=0 period=70n delay=14n rise=1n fall=1n width=12n type=pulse
_vRBL_EN\\<12\\> (RBL_EN\\<12\\> 0) vsource val0=1.8 val1=0 period=70n delay=14n rise=1n fall=1n width=12n type=pulse
_vRBL_EN\\<13\\> (RBL_EN\\<13\\> 0) vsource val0=1.8 val1=0 period=70n delay=14n rise=1n fall=1n width=12n type=pulse
_vRBL_EN\\<15\\> (RBL_EN\\<15\\> 0) vsource val0=1.8 val1=0 period=70n delay=14n rise=1n fall=1n width=12n type=pulse
_vRBL_EN\\<14\\> (RBL_EN\\<14\\> 0) vsource val0=1.8 val1=0 period=70n delay=14n rise=1n fall=1n width=12n type=pulse

_vGND (GND 0) vsource dc=0 type=dc
_vVDD (VDD 0) vsource dc=1.8 type=dc

_vRWL\\<0\\> (RWL\\<0\\> 0) vsource val0=0 val1=1.8 period=70n delay=30n rise=1n fall=1n width=10n type=pulse
_vRWL\\<1\\> (RWL\\<1\\> 0) vsource val0=0 val1=1.8 period=70n delay=30n rise=1n fall=1n width=10n type=pulse
_vRWL\\<2\\> (RWL\\<2\\> 0) vsource val0=0 val1=0 period=70n delay=30n rise=1n fall=1n width=10n type=pulse
_vRWL\\<3\\> (RWL\\<3\\> 0) vsource val0=0 val1=0 period=70n delay=30n rise=1n fall=1n width=10n type=pulse
_vRWL\\<4\\> (RWL\\<4\\> 0) vsource val0=0 val1=0 period=70n delay=30n rise=1n fall=1n width=10n type=pulse
_vRWL\\<5\\> (RWL\\<5\\> 0) vsource val0=0 val1=0 period=70n delay=30n rise=1n fall=1n width=10n type=pulse
_vRWL\\<6\\> (RWL\\<6\\> 0) vsource val0=0 val1=0 period=70n delay=30n rise=1n fall=1n width=10n type=pulse
_vRWL\\<7\\> (RWL\\<7\\> 0) vsource val0=0 val1=0 period=70n delay=30n rise=1n fall=1n width=10n type=pulse
_vRWL\\<8\\> (RWL\\<8\\> 0) vsource val0=0 val1=0 period=70n delay=30n rise=1n fall=1n width=10n type=pulse
_vRWL\\<9\\> (RWL\\<9\\> 0) vsource val0=0 val1=0 period=70n delay=30n rise=1n fall=1n width=10n type=pulse
_vRWL\\<10\\> (RWL\\<10\\> 0) vsource val0=0 val1=0 period=70n delay=30n rise=1n fall=1n width=10n type=pulse
_vRWL\\<11\\> (RWL\\<11\\> 0) vsource val0=0 val1=0 period=70n delay=30n rise=1n fall=1n width=10n type=pulse
_vRWL\\<12\\> (RWL\\<12\\> 0) vsource val0=0 val1=0 period=70n delay=30n rise=1n fall=1n width=10n type=pulse
_vRWL\\<13\\> (RWL\\<13\\> 0) vsource val0=0 val1=0 period=70n delay=30n rise=1n fall=1n width=10n type=pulse
_vRWL\\<14\\> (RWL\\<14\\> 0) vsource val0=0 val1=0 period=70n delay=30n rise=1n fall=1n width=10n type=pulse
_vRWL\\<15\\> (RWL\\<15\\> 0) vsource val0=0 val1=0 period=70n delay=30n rise=1n fall=1n width=10n type=pulse
_vRWL\\<16\\> (RWL\\<16\\> 0) vsource val0=0 val1=0 period=70n delay=30n rise=1n fall=1n width=10n type=pulse
_vRWL\\<17\\> (RWL\\<17\\> 0) vsource val0=0 val1=0 period=70n delay=30n rise=1n fall=1n width=10n type=pulse
_vRWL\\<18\\> (RWL\\<18\\> 0) vsource val0=0 val1=0 period=70n delay=30n rise=1n fall=1n width=10n type=pulse
_vRWL\\<19\\> (RWL\\<19\\> 0) vsource val0=0 val1=0 period=70n delay=30n rise=1n fall=1n width=10n type=pulse
_vRWL\\<20\\> (RWL\\<20\\> 0) vsource val0=0 val1=0 period=70n delay=30n rise=1n fall=1n width=10n type=pulse
_vRWL\\<21\\> (RWL\\<21\\> 0) vsource val0=0 val1=0 period=70n delay=30n rise=1n fall=1n width=10n type=pulse
_vRWL\\<22\\> (RWL\\<22\\> 0) vsource val0=0 val1=0 period=70n delay=30n rise=1n fall=1n width=10n type=pulse
_vRWL\\<23\\> (RWL\\<23\\> 0) vsource val0=0 val1=0 period=70n delay=30n rise=1n fall=1n width=10n type=pulse
_vRWL\\<24\\> (RWL\\<24\\> 0) vsource val0=0 val1=0 period=70n delay=30n rise=1n fall=1n width=10n type=pulse
_vRWL\\<25\\> (RWL\\<25\\> 0) vsource val0=0 val1=0 period=70n delay=30n rise=1n fall=1n width=10n type=pulse
_vRWL\\<26\\> (RWL\\<26\\> 0) vsource val0=0 val1=0 period=70n delay=30n rise=1n fall=1n width=10n type=pulse
_vRWL\\<27\\> (RWL\\<27\\> 0) vsource val0=0 val1=0 period=70n delay=30n rise=1n fall=1n width=10n type=pulse
_vRWL\\<28\\> (RWL\\<28\\> 0) vsource val0=0 val1=0 period=70n delay=30n rise=1n fall=1n width=10n type=pulse
_vRWL\\<29\\> (RWL\\<29\\> 0) vsource val0=0 val1=0 period=70n delay=30n rise=1n fall=1n width=10n type=pulse
_vRWL\\<30\\> (RWL\\<30\\> 0) vsource val0=0 val1=0 period=70n delay=30n rise=1n fall=1n width=10n type=pulse
_vRWL\\<31\\> (RWL\\<31\\> 0) vsource val0=0 val1=0 period=70n delay=30n rise=1n fall=1n width=10n type=pulse
_vRWL\\<32\\> (RWL\\<32\\> 0) vsource val0=0 val1=0 period=70n delay=30n rise=1n fall=1n width=10n type=pulse
_vRWL\\<33\\> (RWL\\<33\\> 0) vsource val0=0 val1=0 period=70n delay=30n rise=1n fall=1n width=10n type=pulse
_vRWL\\<34\\> (RWL\\<34\\> 0) vsource val0=0 val1=0 period=70n delay=30n rise=1n fall=1n width=10n type=pulse
_vRWL\\<35\\> (RWL\\<35\\> 0) vsource val0=0 val1=0 period=70n delay=30n rise=1n fall=1n width=10n type=pulse
_vRWL\\<36\\> (RWL\\<36\\> 0) vsource val0=0 val1=0 period=70n delay=30n rise=1n fall=1n width=10n type=pulse
_vRWL\\<37\\> (RWL\\<37\\> 0) vsource val0=0 val1=0 period=70n delay=30n rise=1n fall=1n width=10n type=pulse
_vRWL\\<38\\> (RWL\\<38\\> 0) vsource val0=0 val1=0 period=70n delay=30n rise=1n fall=1n width=10n type=pulse
_vRWL\\<39\\> (RWL\\<39\\> 0) vsource val0=0 val1=0 period=70n delay=30n rise=1n fall=1n width=10n type=pulse
_vRWL\\<40\\> (RWL\\<40\\> 0) vsource val0=0 val1=0 period=70n delay=30n rise=1n fall=1n width=10n type=pulse
_vRWL\\<41\\> (RWL\\<41\\> 0) vsource val0=0 val1=0 period=70n delay=30n rise=1n fall=1n width=10n type=pulse
_vRWL\\<42\\> (RWL\\<42\\> 0) vsource val0=0 val1=0 period=70n delay=30n rise=1n fall=1n width=10n type=pulse
_vRWL\\<43\\> (RWL\\<43\\> 0) vsource val0=0 val1=0 period=70n delay=30n rise=1n fall=1n width=10n type=pulse
_vRWL\\<44\\> (RWL\\<44\\> 0) vsource val0=0 val1=0 period=70n delay=30n rise=1n fall=1n width=10n type=pulse
_vRWL\\<45\\> (RWL\\<45\\> 0) vsource val0=0 val1=0 period=70n delay=30n rise=1n fall=1n width=10n type=pulse
_vRWL\\<46\\> (RWL\\<46\\> 0) vsource val0=0 val1=0 period=70n delay=30n rise=1n fall=1n width=10n type=pulse
_vRWL\\<47\\> (RWL\\<47\\> 0) vsource val0=0 val1=0 period=70n delay=30n rise=1n fall=1n width=10n type=pulse
_vRWL\\<48\\> (RWL\\<48\\> 0) vsource val0=0 val1=0 period=70n delay=30n rise=1n fall=1n width=10n type=pulse
_vRWL\\<49\\> (RWL\\<49\\> 0) vsource val0=0 val1=0 period=70n delay=30n rise=1n fall=1n width=10n type=pulse
_vRWL\\<50\\> (RWL\\<50\\> 0) vsource val0=0 val1=0 period=70n delay=30n rise=1n fall=1n width=10n type=pulse
_vRWL\\<51\\> (RWL\\<51\\> 0) vsource val0=0 val1=0 period=70n delay=30n rise=1n fall=1n width=10n type=pulse
_vRWL\\<52\\> (RWL\\<52\\> 0) vsource val0=0 val1=0 period=70n delay=30n rise=1n fall=1n width=10n type=pulse
_vRWL\\<53\\> (RWL\\<53\\> 0) vsource val0=0 val1=0 period=70n delay=30n rise=1n fall=1n width=10n type=pulse
_vRWL\\<54\\> (RWL\\<54\\> 0) vsource val0=0 val1=0 period=70n delay=30n rise=1n fall=1n width=10n type=pulse
_vRWL\\<55\\> (RWL\\<55\\> 0) vsource val0=0 val1=0 period=70n delay=30n rise=1n fall=1n width=10n type=pulse
_vRWL\\<56\\> (RWL\\<56\\> 0) vsource val0=0 val1=0 period=70n delay=30n rise=1n fall=1n width=10n type=pulse
_vRWL\\<57\\> (RWL\\<57\\> 0) vsource val0=0 val1=0 period=70n delay=30n rise=1n fall=1n width=10n type=pulse
_vRWL\\<58\\> (RWL\\<58\\> 0) vsource val0=0 val1=0 period=70n delay=30n rise=1n fall=1n width=10n type=pulse
_vRWL\\<59\\> (RWL\\<59\\> 0) vsource val0=0 val1=0 period=70n delay=30n rise=1n fall=1n width=10n type=pulse
_vRWL\\<60\\> (RWL\\<60\\> 0) vsource val0=0 val1=0 period=70n delay=30n rise=1n fall=1n width=10n type=pulse
_vRWL\\<61\\> (RWL\\<61\\> 0) vsource val0=0 val1=0 period=70n delay=30n rise=1n fall=1n width=10n type=pulse
_vRWL\\<62\\> (RWL\\<62\\> 0) vsource val0=0 val1=0 period=70n delay=30n rise=1n fall=1n width=10n type=pulse
_vRWL\\<63\\> (RWL\\<63\\> 0) vsource val0=0 val1=0 period=70n delay=30n rise=1n fall=1n width=10n type=pulse
_vRWL\\<64\\> (RWL\\<64\\> 0) vsource val0=0 val1=0 period=70n delay=30n rise=1n fall=1n width=10n type=pulse
_vRWL\\<65\\> (RWL\\<65\\> 0) vsource val0=0 val1=0 period=70n delay=30n rise=1n fall=1n width=10n type=pulse
_vRWL\\<66\\> (RWL\\<66\\> 0) vsource val0=0 val1=0 period=70n delay=30n rise=1n fall=1n width=10n type=pulse
_vRWL\\<67\\> (RWL\\<67\\> 0) vsource val0=0 val1=0 period=70n delay=30n rise=1n fall=1n width=10n type=pulse
_vRWL\\<68\\> (RWL\\<68\\> 0) vsource val0=0 val1=0 period=70n delay=30n rise=1n fall=1n width=10n type=pulse
_vRWL\\<69\\> (RWL\\<69\\> 0) vsource val0=0 val1=0 period=70n delay=30n rise=1n fall=1n width=10n type=pulse
_vRWL\\<70\\> (RWL\\<70\\> 0) vsource val0=0 val1=0 period=70n delay=30n rise=1n fall=1n width=10n type=pulse
_vRWL\\<71\\> (RWL\\<71\\> 0) vsource val0=0 val1=0 period=70n delay=30n rise=1n fall=1n width=10n type=pulse
_vRWL\\<72\\> (RWL\\<72\\> 0) vsource val0=0 val1=0 period=70n delay=30n rise=1n fall=1n width=10n type=pulse
_vRWL\\<73\\> (RWL\\<73\\> 0) vsource val0=0 val1=0 period=70n delay=30n rise=1n fall=1n width=10n type=pulse
_vRWL\\<74\\> (RWL\\<74\\> 0) vsource val0=0 val1=0 period=70n delay=30n rise=1n fall=1n width=10n type=pulse
_vRWL\\<75\\> (RWL\\<75\\> 0) vsource val0=0 val1=0 period=70n delay=30n rise=1n fall=1n width=10n type=pulse
_vRWL\\<76\\> (RWL\\<76\\> 0) vsource val0=0 val1=0 period=70n delay=30n rise=1n fall=1n width=10n type=pulse
_vRWL\\<77\\> (RWL\\<77\\> 0) vsource val0=0 val1=0 period=70n delay=30n rise=1n fall=1n width=10n type=pulse
_vRWL\\<78\\> (RWL\\<78\\> 0) vsource val0=0 val1=0 period=70n delay=30n rise=1n fall=1n width=10n type=pulse
_vRWL\\<79\\> (RWL\\<79\\> 0) vsource val0=0 val1=0 period=70n delay=30n rise=1n fall=1n width=10n type=pulse
_vRWL\\<80\\> (RWL\\<80\\> 0) vsource val0=0 val1=0 period=70n delay=30n rise=1n fall=1n width=10n type=pulse
_vRWL\\<81\\> (RWL\\<81\\> 0) vsource val0=0 val1=0 period=70n delay=30n rise=1n fall=1n width=10n type=pulse
_vRWL\\<82\\> (RWL\\<82\\> 0) vsource val0=0 val1=0 period=70n delay=30n rise=1n fall=1n width=10n type=pulse
_vRWL\\<83\\> (RWL\\<83\\> 0) vsource val0=0 val1=0 period=70n delay=30n rise=1n fall=1n width=10n type=pulse
_vRWL\\<84\\> (RWL\\<84\\> 0) vsource val0=0 val1=0 period=70n delay=30n rise=1n fall=1n width=10n type=pulse
_vRWL\\<85\\> (RWL\\<85\\> 0) vsource val0=0 val1=0 period=70n delay=30n rise=1n fall=1n width=10n type=pulse
_vRWL\\<86\\> (RWL\\<86\\> 0) vsource val0=0 val1=0 period=70n delay=30n rise=1n fall=1n width=10n type=pulse
_vRWL\\<87\\> (RWL\\<87\\> 0) vsource val0=0 val1=0 period=70n delay=30n rise=1n fall=1n width=10n type=pulse
_vRWL\\<88\\> (RWL\\<88\\> 0) vsource val0=0 val1=0 period=70n delay=30n rise=1n fall=1n width=10n type=pulse
_vRWL\\<89\\> (RWL\\<89\\> 0) vsource val0=0 val1=0 period=70n delay=30n rise=1n fall=1n width=10n type=pulse
_vRWL\\<90\\> (RWL\\<90\\> 0) vsource val0=0 val1=0 period=70n delay=30n rise=1n fall=1n width=10n type=pulse
_vRWL\\<91\\> (RWL\\<91\\> 0) vsource val0=0 val1=0 period=70n delay=30n rise=1n fall=1n width=10n type=pulse
_vRWL\\<92\\> (RWL\\<92\\> 0) vsource val0=0 val1=0 period=70n delay=30n rise=1n fall=1n width=10n type=pulse
_vRWL\\<93\\> (RWL\\<93\\> 0) vsource val0=0 val1=0 period=70n delay=30n rise=1n fall=1n width=10n type=pulse
_vRWL\\<94\\> (RWL\\<94\\> 0) vsource val0=0 val1=0 period=70n delay=30n rise=1n fall=1n width=10n type=pulse
_vRWL\\<95\\> (RWL\\<95\\> 0) vsource val0=0 val1=0 period=70n delay=30n rise=1n fall=1n width=10n type=pulse
_vRWL\\<96\\> (RWL\\<96\\> 0) vsource val0=0 val1=0 period=70n delay=30n rise=1n fall=1n width=10n type=pulse
_vRWL\\<97\\> (RWL\\<97\\> 0) vsource val0=0 val1=0 period=70n delay=30n rise=1n fall=1n width=10n type=pulse
_vRWL\\<98\\> (RWL\\<98\\> 0) vsource val0=0 val1=0 period=70n delay=30n rise=1n fall=1n width=10n type=pulse
_vRWL\\<99\\> (RWL\\<99\\> 0) vsource val0=0 val1=0 period=70n delay=30n rise=1n fall=1n width=10n type=pulse
_vRWL\\<100\\> (RWL\\<100\\> 0) vsource val0=0 val1=0 period=70n delay=30n rise=1n fall=1n width=10n type=pulse
_vRWL\\<101\\> (RWL\\<101\\> 0) vsource val0=0 val1=0 period=70n delay=30n rise=1n fall=1n width=10n type=pulse
_vRWL\\<102\\> (RWL\\<102\\> 0) vsource val0=0 val1=0 period=70n delay=30n rise=1n fall=1n width=10n type=pulse
_vRWL\\<103\\> (RWL\\<103\\> 0) vsource val0=0 val1=0 period=70n delay=30n rise=1n fall=1n width=10n type=pulse
_vRWL\\<104\\> (RWL\\<104\\> 0) vsource val0=0 val1=0 period=70n delay=30n rise=1n fall=1n width=10n type=pulse
_vRWL\\<105\\> (RWL\\<105\\> 0) vsource val0=0 val1=0 period=70n delay=30n rise=1n fall=1n width=10n type=pulse
_vRWL\\<106\\> (RWL\\<106\\> 0) vsource val0=0 val1=0 period=70n delay=30n rise=1n fall=1n width=10n type=pulse
_vRWL\\<107\\> (RWL\\<107\\> 0) vsource val0=0 val1=0 period=70n delay=30n rise=1n fall=1n width=10n type=pulse
_vRWL\\<108\\> (RWL\\<108\\> 0) vsource val0=0 val1=0 period=70n delay=30n rise=1n fall=1n width=10n type=pulse
_vRWL\\<109\\> (RWL\\<109\\> 0) vsource val0=0 val1=0 period=70n delay=30n rise=1n fall=1n width=10n type=pulse
_vRWL\\<110\\> (RWL\\<110\\> 0) vsource val0=0 val1=0 period=70n delay=30n rise=1n fall=1n width=10n type=pulse
_vRWL\\<111\\> (RWL\\<111\\> 0) vsource val0=0 val1=0 period=70n delay=30n rise=1n fall=1n width=10n type=pulse
_vRWL\\<112\\> (RWL\\<112\\> 0) vsource val0=0 val1=0 period=70n delay=30n rise=1n fall=1n width=10n type=pulse
_vRWL\\<113\\> (RWL\\<113\\> 0) vsource val0=0 val1=0 period=70n delay=30n rise=1n fall=1n width=10n type=pulse
_vRWL\\<114\\> (RWL\\<114\\> 0) vsource val0=0 val1=0 period=70n delay=30n rise=1n fall=1n width=10n type=pulse
_vRWL\\<115\\> (RWL\\<115\\> 0) vsource val0=0 val1=0 period=70n delay=30n rise=1n fall=1n width=10n type=pulse
_vRWL\\<116\\> (RWL\\<116\\> 0) vsource val0=0 val1=0 period=70n delay=30n rise=1n fall=1n width=10n type=pulse
_vRWL\\<117\\> (RWL\\<117\\> 0) vsource val0=0 val1=0 period=70n delay=30n rise=1n fall=1n width=10n type=pulse
_vRWL\\<118\\> (RWL\\<118\\> 0) vsource val0=0 val1=0 period=70n delay=30n rise=1n fall=1n width=10n type=pulse
_vRWL\\<119\\> (RWL\\<119\\> 0) vsource val0=0 val1=0 period=70n delay=30n rise=1n fall=1n width=10n type=pulse
_vRWL\\<120\\> (RWL\\<120\\> 0) vsource val0=0 val1=0 period=70n delay=30n rise=1n fall=1n width=10n type=pulse
_vRWL\\<121\\> (RWL\\<121\\> 0) vsource val0=0 val1=0 period=70n delay=30n rise=1n fall=1n width=10n type=pulse
_vRWL\\<122\\> (RWL\\<122\\> 0) vsource val0=0 val1=0 period=70n delay=30n rise=1n fall=1n width=10n type=pulse
_vRWL\\<123\\> (RWL\\<123\\> 0) vsource val0=0 val1=0 period=70n delay=30n rise=1n fall=1n width=10n type=pulse
_vRWL\\<124\\> (RWL\\<124\\> 0) vsource val0=0 val1=0 period=70n delay=30n rise=1n fall=1n width=10n type=pulse
_vRWL\\<125\\> (RWL\\<125\\> 0) vsource val0=0 val1=0 period=70n delay=30n rise=1n fall=1n width=10n type=pulse
_vRWL\\<126\\> (RWL\\<126\\> 0) vsource val0=0 val1=0 period=70n delay=30n rise=1n fall=1n width=10n type=pulse
_vRWL\\<127\\> (RWL\\<127\\> 0) vsource val0=0 val1=0 period=70n delay=30n rise=1n fall=1n width=10n type=pulse

_vWWL\\<0\\> (WWL\\<0\\> 0) vsource val0=0 val1=1.8 period=70n delay=2n rise=1n fall=1n width=10n type=pulse
_vWWL\\<1\\> (WWL\\<1\\> 0) vsource val0=0 val1=1.8 period=70n delay=15n rise=1n fall=1n width=10n type=pulse
_vWWL\\<2\\> (WWL\\<2\\> 0) vsource val0=0 val1=0 period=70n delay=2n rise=1n fall=1n width=10n type=pulse
_vWWL\\<3\\> (WWL\\<3\\> 0) vsource val0=0 val1=0 period=70n delay=2n rise=1n fall=1n width=10n type=pulse
_vWWL\\<4\\> (WWL\\<4\\> 0) vsource val0=0 val1=0 period=70n delay=2n rise=1n fall=1n width=10n type=pulse
_vWWL\\<5\\> (WWL\\<5\\> 0) vsource val0=0 val1=0 period=70n delay=2n rise=1n fall=1n width=10n type=pulse
_vWWL\\<6\\> (WWL\\<6\\> 0) vsource val0=0 val1=0 period=70n delay=2n rise=1n fall=1n width=10n type=pulse
_vWWL\\<7\\> (WWL\\<7\\> 0) vsource val0=0 val1=0 period=70n delay=2n rise=1n fall=1n width=10n type=pulse
_vWWL\\<8\\> (WWL\\<8\\> 0) vsource val0=0 val1=0 period=70n delay=2n rise=1n fall=1n width=10n type=pulse
_vWWL\\<9\\> (WWL\\<9\\> 0) vsource val0=0 val1=0 period=70n delay=2n rise=1n fall=1n width=10n type=pulse
_vWWL\\<10\\> (WWL\\<10\\> 0) vsource val0=0 val1=0 period=70n delay=2n rise=1n fall=1n width=10n type=pulse
_vWWL\\<11\\> (WWL\\<11\\> 0) vsource val0=0 val1=0 period=70n delay=2n rise=1n fall=1n width=10n type=pulse
_vWWL\\<12\\> (WWL\\<12\\> 0) vsource val0=0 val1=0 period=70n delay=2n rise=1n fall=1n width=10n type=pulse
_vWWL\\<13\\> (WWL\\<13\\> 0) vsource val0=0 val1=0 period=70n delay=2n rise=1n fall=1n width=10n type=pulse
_vWWL\\<14\\> (WWL\\<14\\> 0) vsource val0=0 val1=0 period=70n delay=2n rise=1n fall=1n width=10n type=pulse
_vWWL\\<15\\> (WWL\\<15\\> 0) vsource val0=0 val1=0 period=70n delay=2n rise=1n fall=1n width=10n type=pulse
_vWWL\\<16\\> (WWL\\<16\\> 0) vsource val0=0 val1=0 period=70n delay=2n rise=1n fall=1n width=10n type=pulse
_vWWL\\<17\\> (WWL\\<17\\> 0) vsource val0=0 val1=0 period=70n delay=2n rise=1n fall=1n width=10n type=pulse
_vWWL\\<18\\> (WWL\\<18\\> 0) vsource val0=0 val1=0 period=70n delay=2n rise=1n fall=1n width=10n type=pulse
_vWWL\\<19\\> (WWL\\<19\\> 0) vsource val0=0 val1=0 period=70n delay=2n rise=1n fall=1n width=10n type=pulse
_vWWL\\<20\\> (WWL\\<20\\> 0) vsource val0=0 val1=0 period=70n delay=2n rise=1n fall=1n width=10n type=pulse
_vWWL\\<21\\> (WWL\\<21\\> 0) vsource val0=0 val1=0 period=70n delay=2n rise=1n fall=1n width=10n type=pulse
_vWWL\\<22\\> (WWL\\<22\\> 0) vsource val0=0 val1=0 period=70n delay=2n rise=1n fall=1n width=10n type=pulse
_vWWL\\<23\\> (WWL\\<23\\> 0) vsource val0=0 val1=0 period=70n delay=2n rise=1n fall=1n width=10n type=pulse
_vWWL\\<24\\> (WWL\\<24\\> 0) vsource val0=0 val1=0 period=70n delay=2n rise=1n fall=1n width=10n type=pulse
_vWWL\\<25\\> (WWL\\<25\\> 0) vsource val0=0 val1=0 period=70n delay=2n rise=1n fall=1n width=10n type=pulse
_vWWL\\<26\\> (WWL\\<26\\> 0) vsource val0=0 val1=0 period=70n delay=2n rise=1n fall=1n width=10n type=pulse
_vWWL\\<27\\> (WWL\\<27\\> 0) vsource val0=0 val1=0 period=70n delay=2n rise=1n fall=1n width=10n type=pulse
_vWWL\\<28\\> (WWL\\<28\\> 0) vsource val0=0 val1=0 period=70n delay=2n rise=1n fall=1n width=10n type=pulse
_vWWL\\<29\\> (WWL\\<29\\> 0) vsource val0=0 val1=0 period=70n delay=2n rise=1n fall=1n width=10n type=pulse
_vWWL\\<30\\> (WWL\\<30\\> 0) vsource val0=0 val1=0 period=70n delay=2n rise=1n fall=1n width=10n type=pulse
_vWWL\\<31\\> (WWL\\<31\\> 0) vsource val0=0 val1=0 period=70n delay=2n rise=1n fall=1n width=10n type=pulse
_vWWL\\<32\\> (WWL\\<32\\> 0) vsource val0=0 val1=0 period=70n delay=2n rise=1n fall=1n width=10n type=pulse
_vWWL\\<33\\> (WWL\\<33\\> 0) vsource val0=0 val1=0 period=70n delay=2n rise=1n fall=1n width=10n type=pulse
_vWWL\\<34\\> (WWL\\<34\\> 0) vsource val0=0 val1=0 period=70n delay=2n rise=1n fall=1n width=10n type=pulse
_vWWL\\<35\\> (WWL\\<35\\> 0) vsource val0=0 val1=0 period=70n delay=2n rise=1n fall=1n width=10n type=pulse
_vWWL\\<36\\> (WWL\\<36\\> 0) vsource val0=0 val1=0 period=70n delay=2n rise=1n fall=1n width=10n type=pulse
_vWWL\\<37\\> (WWL\\<37\\> 0) vsource val0=0 val1=0 period=70n delay=2n rise=1n fall=1n width=10n type=pulse
_vWWL\\<38\\> (WWL\\<38\\> 0) vsource val0=0 val1=0 period=70n delay=2n rise=1n fall=1n width=10n type=pulse
_vWWL\\<39\\> (WWL\\<39\\> 0) vsource val0=0 val1=0 period=70n delay=2n rise=1n fall=1n width=10n type=pulse
_vWWL\\<40\\> (WWL\\<40\\> 0) vsource val0=0 val1=0 period=70n delay=2n rise=1n fall=1n width=10n type=pulse
_vWWL\\<41\\> (WWL\\<41\\> 0) vsource val0=0 val1=0 period=70n delay=2n rise=1n fall=1n width=10n type=pulse
_vWWL\\<42\\> (WWL\\<42\\> 0) vsource val0=0 val1=0 period=70n delay=2n rise=1n fall=1n width=10n type=pulse
_vWWL\\<43\\> (WWL\\<43\\> 0) vsource val0=0 val1=0 period=70n delay=2n rise=1n fall=1n width=10n type=pulse
_vWWL\\<44\\> (WWL\\<44\\> 0) vsource val0=0 val1=0 period=70n delay=2n rise=1n fall=1n width=10n type=pulse
_vWWL\\<45\\> (WWL\\<45\\> 0) vsource val0=0 val1=0 period=70n delay=2n rise=1n fall=1n width=10n type=pulse
_vWWL\\<46\\> (WWL\\<46\\> 0) vsource val0=0 val1=0 period=70n delay=2n rise=1n fall=1n width=10n type=pulse
_vWWL\\<47\\> (WWL\\<47\\> 0) vsource val0=0 val1=0 period=70n delay=2n rise=1n fall=1n width=10n type=pulse
_vWWL\\<48\\> (WWL\\<48\\> 0) vsource val0=0 val1=0 period=70n delay=2n rise=1n fall=1n width=10n type=pulse
_vWWL\\<49\\> (WWL\\<49\\> 0) vsource val0=0 val1=0 period=70n delay=2n rise=1n fall=1n width=10n type=pulse
_vWWL\\<50\\> (WWL\\<50\\> 0) vsource val0=0 val1=0 period=70n delay=2n rise=1n fall=1n width=10n type=pulse
_vWWL\\<51\\> (WWL\\<51\\> 0) vsource val0=0 val1=0 period=70n delay=2n rise=1n fall=1n width=10n type=pulse
_vWWL\\<52\\> (WWL\\<52\\> 0) vsource val0=0 val1=0 period=70n delay=2n rise=1n fall=1n width=10n type=pulse
_vWWL\\<53\\> (WWL\\<53\\> 0) vsource val0=0 val1=0 period=70n delay=2n rise=1n fall=1n width=10n type=pulse
_vWWL\\<54\\> (WWL\\<54\\> 0) vsource val0=0 val1=0 period=70n delay=2n rise=1n fall=1n width=10n type=pulse
_vWWL\\<55\\> (WWL\\<55\\> 0) vsource val0=0 val1=0 period=70n delay=2n rise=1n fall=1n width=10n type=pulse
_vWWL\\<56\\> (WWL\\<56\\> 0) vsource val0=0 val1=0 period=70n delay=2n rise=1n fall=1n width=10n type=pulse
_vWWL\\<57\\> (WWL\\<57\\> 0) vsource val0=0 val1=0 period=70n delay=2n rise=1n fall=1n width=10n type=pulse
_vWWL\\<58\\> (WWL\\<58\\> 0) vsource val0=0 val1=0 period=70n delay=2n rise=1n fall=1n width=10n type=pulse
_vWWL\\<59\\> (WWL\\<59\\> 0) vsource val0=0 val1=0 period=70n delay=2n rise=1n fall=1n width=10n type=pulse
_vWWL\\<60\\> (WWL\\<60\\> 0) vsource val0=0 val1=0 period=70n delay=2n rise=1n fall=1n width=10n type=pulse
_vWWL\\<61\\> (WWL\\<61\\> 0) vsource val0=0 val1=0 period=70n delay=2n rise=1n fall=1n width=10n type=pulse
_vWWL\\<62\\> (WWL\\<62\\> 0) vsource val0=0 val1=0 period=70n delay=2n rise=1n fall=1n width=10n type=pulse
_vWWL\\<63\\> (WWL\\<63\\> 0) vsource val0=0 val1=0 period=70n delay=2n rise=1n fall=1n width=10n type=pulse
_vWWL\\<64\\> (WWL\\<64\\> 0) vsource val0=0 val1=0 period=70n delay=2n rise=1n fall=1n width=10n type=pulse
_vWWL\\<65\\> (WWL\\<65\\> 0) vsource val0=0 val1=0 period=70n delay=2n rise=1n fall=1n width=10n type=pulse
_vWWL\\<66\\> (WWL\\<66\\> 0) vsource val0=0 val1=0 period=70n delay=2n rise=1n fall=1n width=10n type=pulse
_vWWL\\<67\\> (WWL\\<67\\> 0) vsource val0=0 val1=0 period=70n delay=2n rise=1n fall=1n width=10n type=pulse
_vWWL\\<68\\> (WWL\\<68\\> 0) vsource val0=0 val1=0 period=70n delay=2n rise=1n fall=1n width=10n type=pulse
_vWWL\\<69\\> (WWL\\<69\\> 0) vsource val0=0 val1=0 period=70n delay=2n rise=1n fall=1n width=10n type=pulse
_vWWL\\<70\\> (WWL\\<70\\> 0) vsource val0=0 val1=0 period=70n delay=2n rise=1n fall=1n width=10n type=pulse
_vWWL\\<71\\> (WWL\\<71\\> 0) vsource val0=0 val1=0 period=70n delay=2n rise=1n fall=1n width=10n type=pulse
_vWWL\\<72\\> (WWL\\<72\\> 0) vsource val0=0 val1=0 period=70n delay=2n rise=1n fall=1n width=10n type=pulse
_vWWL\\<73\\> (WWL\\<73\\> 0) vsource val0=0 val1=0 period=70n delay=2n rise=1n fall=1n width=10n type=pulse
_vWWL\\<74\\> (WWL\\<74\\> 0) vsource val0=0 val1=0 period=70n delay=2n rise=1n fall=1n width=10n type=pulse
_vWWL\\<75\\> (WWL\\<75\\> 0) vsource val0=0 val1=0 period=70n delay=2n rise=1n fall=1n width=10n type=pulse
_vWWL\\<76\\> (WWL\\<76\\> 0) vsource val0=0 val1=0 period=70n delay=2n rise=1n fall=1n width=10n type=pulse
_vWWL\\<77\\> (WWL\\<77\\> 0) vsource val0=0 val1=0 period=70n delay=2n rise=1n fall=1n width=10n type=pulse
_vWWL\\<78\\> (WWL\\<78\\> 0) vsource val0=0 val1=0 period=70n delay=2n rise=1n fall=1n width=10n type=pulse
_vWWL\\<79\\> (WWL\\<79\\> 0) vsource val0=0 val1=0 period=70n delay=2n rise=1n fall=1n width=10n type=pulse
_vWWL\\<80\\> (WWL\\<80\\> 0) vsource val0=0 val1=0 period=70n delay=2n rise=1n fall=1n width=10n type=pulse
_vWWL\\<81\\> (WWL\\<81\\> 0) vsource val0=0 val1=0 period=70n delay=2n rise=1n fall=1n width=10n type=pulse
_vWWL\\<82\\> (WWL\\<82\\> 0) vsource val0=0 val1=0 period=70n delay=2n rise=1n fall=1n width=10n type=pulse
_vWWL\\<83\\> (WWL\\<83\\> 0) vsource val0=0 val1=0 period=70n delay=2n rise=1n fall=1n width=10n type=pulse
_vWWL\\<84\\> (WWL\\<84\\> 0) vsource val0=0 val1=0 period=70n delay=2n rise=1n fall=1n width=10n type=pulse
_vWWL\\<85\\> (WWL\\<85\\> 0) vsource val0=0 val1=0 period=70n delay=2n rise=1n fall=1n width=10n type=pulse
_vWWL\\<86\\> (WWL\\<86\\> 0) vsource val0=0 val1=0 period=70n delay=2n rise=1n fall=1n width=10n type=pulse
_vWWL\\<87\\> (WWL\\<87\\> 0) vsource val0=0 val1=0 period=70n delay=2n rise=1n fall=1n width=10n type=pulse
_vWWL\\<88\\> (WWL\\<88\\> 0) vsource val0=0 val1=0 period=70n delay=2n rise=1n fall=1n width=10n type=pulse
_vWWL\\<89\\> (WWL\\<89\\> 0) vsource val0=0 val1=0 period=70n delay=2n rise=1n fall=1n width=10n type=pulse
_vWWL\\<90\\> (WWL\\<90\\> 0) vsource val0=0 val1=0 period=70n delay=2n rise=1n fall=1n width=10n type=pulse
_vWWL\\<91\\> (WWL\\<91\\> 0) vsource val0=0 val1=0 period=70n delay=2n rise=1n fall=1n width=10n type=pulse
_vWWL\\<92\\> (WWL\\<92\\> 0) vsource val0=0 val1=0 period=70n delay=2n rise=1n fall=1n width=10n type=pulse
_vWWL\\<93\\> (WWL\\<93\\> 0) vsource val0=0 val1=0 period=70n delay=2n rise=1n fall=1n width=10n type=pulse
_vWWL\\<94\\> (WWL\\<94\\> 0) vsource val0=0 val1=0 period=70n delay=2n rise=1n fall=1n width=10n type=pulse
_vWWL\\<95\\> (WWL\\<95\\> 0) vsource val0=0 val1=0 period=70n delay=2n rise=1n fall=1n width=10n type=pulse
_vWWL\\<96\\> (WWL\\<96\\> 0) vsource val0=0 val1=0 period=70n delay=2n rise=1n fall=1n width=10n type=pulse
_vWWL\\<97\\> (WWL\\<97\\> 0) vsource val0=0 val1=0 period=70n delay=2n rise=1n fall=1n width=10n type=pulse
_vWWL\\<98\\> (WWL\\<98\\> 0) vsource val0=0 val1=0 period=70n delay=2n rise=1n fall=1n width=10n type=pulse
_vWWL\\<99\\> (WWL\\<99\\> 0) vsource val0=0 val1=0 period=70n delay=2n rise=1n fall=1n width=10n type=pulse
_vWWL\\<100\\> (WWL\\<100\\> 0) vsource val0=0 val1=0 period=70n delay=2n rise=1n fall=1n width=10n type=pulse
_vWWL\\<101\\> (WWL\\<101\\> 0) vsource val0=0 val1=0 period=70n delay=2n rise=1n fall=1n width=10n type=pulse
_vWWL\\<102\\> (WWL\\<102\\> 0) vsource val0=0 val1=0 period=70n delay=2n rise=1n fall=1n width=10n type=pulse
_vWWL\\<103\\> (WWL\\<103\\> 0) vsource val0=0 val1=0 period=70n delay=2n rise=1n fall=1n width=10n type=pulse
_vWWL\\<104\\> (WWL\\<104\\> 0) vsource val0=0 val1=0 period=70n delay=2n rise=1n fall=1n width=10n type=pulse
_vWWL\\<105\\> (WWL\\<105\\> 0) vsource val0=0 val1=0 period=70n delay=2n rise=1n fall=1n width=10n type=pulse
_vWWL\\<106\\> (WWL\\<106\\> 0) vsource val0=0 val1=0 period=70n delay=2n rise=1n fall=1n width=10n type=pulse
_vWWL\\<107\\> (WWL\\<107\\> 0) vsource val0=0 val1=0 period=70n delay=2n rise=1n fall=1n width=10n type=pulse
_vWWL\\<108\\> (WWL\\<108\\> 0) vsource val0=0 val1=0 period=70n delay=2n rise=1n fall=1n width=10n type=pulse
_vWWL\\<109\\> (WWL\\<109\\> 0) vsource val0=0 val1=0 period=70n delay=2n rise=1n fall=1n width=10n type=pulse
_vWWL\\<110\\> (WWL\\<110\\> 0) vsource val0=0 val1=0 period=70n delay=2n rise=1n fall=1n width=10n type=pulse
_vWWL\\<111\\> (WWL\\<111\\> 0) vsource val0=0 val1=0 period=70n delay=2n rise=1n fall=1n width=10n type=pulse
_vWWL\\<112\\> (WWL\\<112\\> 0) vsource val0=0 val1=0 period=70n delay=2n rise=1n fall=1n width=10n type=pulse
_vWWL\\<113\\> (WWL\\<113\\> 0) vsource val0=0 val1=0 period=70n delay=2n rise=1n fall=1n width=10n type=pulse
_vWWL\\<114\\> (WWL\\<114\\> 0) vsource val0=0 val1=0 period=70n delay=2n rise=1n fall=1n width=10n type=pulse
_vWWL\\<115\\> (WWL\\<115\\> 0) vsource val0=0 val1=0 period=70n delay=2n rise=1n fall=1n width=10n type=pulse
_vWWL\\<116\\> (WWL\\<116\\> 0) vsource val0=0 val1=0 period=70n delay=2n rise=1n fall=1n width=10n type=pulse
_vWWL\\<117\\> (WWL\\<117\\> 0) vsource val0=0 val1=0 period=70n delay=2n rise=1n fall=1n width=10n type=pulse
_vWWL\\<118\\> (WWL\\<118\\> 0) vsource val0=0 val1=0 period=70n delay=2n rise=1n fall=1n width=10n type=pulse
_vWWL\\<119\\> (WWL\\<119\\> 0) vsource val0=0 val1=0 period=70n delay=2n rise=1n fall=1n width=10n type=pulse
_vWWL\\<120\\> (WWL\\<120\\> 0) vsource val0=0 val1=0 period=70n delay=2n rise=1n fall=1n width=10n type=pulse
_vWWL\\<121\\> (WWL\\<121\\> 0) vsource val0=0 val1=0 period=70n delay=2n rise=1n fall=1n width=10n type=pulse
_vWWL\\<122\\> (WWL\\<122\\> 0) vsource val0=0 val1=0 period=70n delay=2n rise=1n fall=1n width=10n type=pulse
_vWWL\\<123\\> (WWL\\<123\\> 0) vsource val0=0 val1=0 period=70n delay=2n rise=1n fall=1n width=10n type=pulse
_vWWL\\<124\\> (WWL\\<124\\> 0) vsource val0=0 val1=0 period=70n delay=2n rise=1n fall=1n width=10n type=pulse
_vWWL\\<125\\> (WWL\\<125\\> 0) vsource val0=0 val1=0 period=70n delay=2n rise=1n fall=1n width=10n type=pulse
_vWWL\\<126\\> (WWL\\<126\\> 0) vsource val0=0 val1=0 period=70n delay=2n rise=1n fall=1n width=10n type=pulse
_vWWL\\<127\\> (WWL\\<127\\> 0) vsource val0=0 val1=0 period=70n delay=2n rise=1n fall=1n width=10n type=pulse
