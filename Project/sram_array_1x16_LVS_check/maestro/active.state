ADE simulation setup
Test Project_sram_array_1: Project/sram_array/schematic, simulator spectre
  Models: /package/eda/cells/ncsu-cdk-1.6.0.beta/models/hspice/public/tsmc18dN.m, /package/eda/cells/ncsu-cdk-1.6.0.beta/models/hspice/public/tsmc18dP.m
  Temperature: 27
  Stimulus WWL<0>: voltage pulse dc=1.8 val0=1.8 val1=0 period=10n delay=0 rise=1p fall=1p width=100p
  Stimulus RWL<0>: voltage pulse dc=1.8 val0=1.8 val1=0 period=10n delay=150p rise=1p fall=1p width=100p
  Stimulus VDD: voltage dc dc=1.8
  Stimulus GND: voltage dc dc=0
  Stimulus WBL<15>: voltage dc dc=1.8
  Stimulus WBL<14>: voltage dc dc=1.8
  Stimulus WBL<13>: voltage dc dc=1.8
  Stimulus WBL<12>: voltage dc dc=1.8
  Stimulus WBL<11>: voltage dc dc=1.8
  Stimulus WBL<10>: voltage dc dc=1.8
  Stimulus WBL<9>: voltage dc dc=1.8
  Stimulus WBL<8>: voltage dc dc=1.8
  Stimulus WBL<7>: voltage dc dc=1.8
  Stimulus WBL<6>: voltage dc dc=1.8
  Stimulus WBL<5>: voltage dc dc=1.8
  Stimulus WBL<4>: voltage dc dc=1.8
  Stimulus WBL<3>: voltage dc dc=1.8
  Stimulus WBL<2>: voltage dc dc=1.8
  Stimulus WBL<1>: voltage dc dc=1.8
  Stimulus WBL<0>: voltage dc dc=1.8
  Stimulus WBLB<15>: voltage dc dc=0
  Stimulus WBLB<14>: voltage dc dc=0
  Stimulus WBLB<13>: voltage dc dc=0
  Stimulus WBLB<12>: voltage dc dc=0
  Stimulus WBLB<11>: voltage dc dc=0
  Stimulus WBLB<10>: voltage dc dc=0
  Stimulus WBLB<9>: voltage dc dc=0
  Stimulus WBLB<8>: voltage dc dc=0
  Stimulus WBLB<7>: voltage dc dc=0
  Stimulus WBLB<6>: voltage dc dc=0
  Stimulus WBLB<5>: voltage dc dc=0
  Stimulus WBLB<4>: voltage dc dc=0
  Stimulus WBLB<3>: voltage dc dc=0
  Stimulus WBLB<2>: voltage dc dc=0
  Stimulus WBLB<1>: voltage dc dc=0
  Stimulus WBLB<0>: voltage dc dc=0
  Analysis tran: stop=10n
  Signals: /RBL<15:0>, /WWL<0>, /RWL<0>, /WBL<15:0>, /WBLB<15:0>
Run mode: Single Run, Sweeps and Corners
