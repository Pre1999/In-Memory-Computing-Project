ADE simulation setup
Run mode: Single Run, Sweeps and Corners
Tests:
  Project_sram_array_1: Project/sram_array/schematic, simulator spectre
